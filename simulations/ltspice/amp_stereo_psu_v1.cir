* =====================================================================
*  amp_stereo_psu_v1.cir  --  GENERATED by tools/make_figures.py, do not edit.
*  Sources: amp_channel_v1.cir (channel, used twice) + psu_v1.cir (B+ supply).
*  Both channels share one transformer / bridge / CRC (B+ node "bp");
*  each channel keeps its own RD1-CD1-RD2-CD2 decoupling (dual-mono style).
*  Fixed bias tracks the mains (VB = VBN * MAINS), as a bias winding on the
*  same transformer would.  .ic starts the supply near steady state.
* =====================================================================
.include ../../models/tubes_amp.inc
.include ../../models/elt10_est.inc
.options plotwinsize=0 numdgt=7
* ---- channel parameters (from amp_channel_v1.cir) ----
.param VBN=-42        ; fixed bias (sweep with .step to study bias)
.param RKO=1 CKO=1p  ; 1R cathode sense (fixed bias). Cathode-bias test: RKO=1.1k CKO=220u VB=0
.param RD1=1k RD2=47k
.param RA1=330k RK2=2.7k   ; 2.7k: DC path via RFB is in parallel, Vgk ~ -0.9 V
.param RT=15k RLA=18k RLB=18.82k
.param RFB=2.7k CFB=1p        ; lead cap removed in v1.4 (v1.1-v1.3 used 1n)
.param RSTEP=3.3k CSTEP=470p ; V1 plate step network (v1.3+). Disable: RSTEP=1e9
.param RZOB=10 CZOB=470n    ; output Zobel (v1.4; v1.3 was 4.7R+100n). Disable: RZOB=1e9
.param RL=4                 ; resistive load (ohm); 1e6 = no load
.param SPK=0                ; 1 = connect the estimated ELT 10 model (then set RL=1e6)
.param DVB=0               ; V4 bias offset (V) relative to VB, for per-tube trim
.param KGA=1460 KGB=1460   ; KG1 of V3 / V4 (equal = matched pair; e.g. KGB=1533 = 5 % less current)
.param LH=10 TU=0.43 KC=0.9995 RAA=6k   ; half-primary L (H), UL tap, coupling, primary Z (plate-plate)
.param VB={VBN*MAINS}
* ---- supply parameters (from psu_v1.cir) ----
.param MAINS=1.0       ; mains factor: 0.9 / 1.0 / 1.1  (99 / 110 / 121 V)
.param VSEC=315.5        ; HT secondary, Vrms at nominal mains (calibrated: B+ = 400 V at idle)
.param RSEC=40         ; transformer source resistance seen from the secondary (ohm)
.param CIN=220u ESR1=0.5     ; reservoir cap + ESR
.param RFIL=47            ; CRC series resistor (drop ~7 V idle)
.param COUT=470u ESR2=0.3   ; B+ cap + ESR
* ---- shared B+ supply ----
* ---- transformer HT winding (Thevenin: ideal sine + source resistance)
VHT ht1 hts SIN(0 {VSEC*MAINS*sqrt(2)} 60)
RS  hts ht2 {RSEC}
RREF ht2 0 10Meg
* ---- silicon bridge
D1 ht1 raw DPWR
D2 ht2 raw DPWR
D3 0 ht1 DPWR
D4 0 ht2 DPWR
.model DPWR D(IS=7.03n RS=0.034 N=1.81 BV=1000 IBV=50n CJO=10p TT=100n)
* ---- CRC filter
CF1 raw c1n {CIN}
RE1 c1n 0 {ESR1}
RF1 raw bp {RFIL}
CF2 bp c2n {COUT}
RE2 c2n 0 {ESR2}
* ---- one channel ----
.subckt AMPCH in out bp
RD1 bp b2 {RD1}
CD1 b2 0 47u
RD2 b2 b3 {RD2}
CD2 b3 0 47u
VBIAS bias 0 {VB}
* ---- V1 : 6N2 (one triode), DC-coupled to LTP
Rin in ing 1k
Rgl ing 0 470k
X1 v1a ing v1k 6N2
RA1 b3 v1a {RA1}
* lag step network on V1 plate (v1.3+): cuts loop gain near 1 MHz, see README 4.3 / 4.5
RST v1a nst {RSTEP}
CST nst 0 {CSTEP}
RK1 v1k fb 100
RK2 fb 0 {RK2}
CK2 fb 0 220u
* Note: NFB injected at v1k, unbypassed part = RK1
RFB out v1k {RFB}
CFB out v1k {CFB}
* ---- LTP : 6N1 both triodes
X3 la v1a lk 6N1
X4 lb lg2 lk 6N1
RG2 v1a lg2 1Meg
CG2 lg2 0 0.47u
RT lk 0 {RT}
RLA b2 la {RLA}
RLB b2 lb {RLB}
* ---- coupling + fixed bias
CCA la ga 0.22u
CCB lb gb 0.22u
RGA ga bias 100k
RGB gb biasb 100k
* per-tube bias trim for V4 (V4 bias = VB + DVB)
VBIASB biasb bias {DVB}
* ---- output: 6P3S-E pair, UL, fixed bias
RSA ga gsa 1.5k
RSB gb gsb 1.5k
X5 pa sa gsa ka 6P3S-E KG1={KGA}
X6 pb sb gsb kb 6P3S-E KG1={KGB}
RG2A ula sa 1k
RG2B ulb sb 1k
RKA ka 0 {RKO}
CKA ka 0 {CKO}
RKB kb 0 {RKO}
CKB kb 0 {CKO}
* ---- OPT 6k p-p, 43% UL, Lp(total)=4*LH=40H, coupling KC (leakage ~ 4*LH*(1-KC^2)), 4 ohm sec
* winding DCRs as explicit resistors (portable LTspice/ngspice)
L1 pa n1 {LH*(1-TU)*(1-TU)}
R1W n1 ula 35
L2 ula n2 {LH*TU*TU}
R2W n2 bp 25
L3 bp n3 {LH*TU*TU}
R3W n3 ulb 25
L4 ulb n4 {LH*(1-TU)*(1-TU)}
R4W n4 pb 35
L5 0 n5 {16*LH/RAA}
R5W n5 out 0.25
K12 L1 L2 {KC}
K13 L1 L3 {KC}
K14 L1 L4 {KC}
K15 L1 L5 {KC}
K23 L2 L3 {KC}
K24 L2 L4 {KC}
K25 L2 L5 {KC}
K34 L3 L4 {KC}
K35 L3 L5 {KC}
K45 L4 L5 {KC}
* ---- output Zobel (v1.4): damps the ~1-2 MHz loop resonance, see README 4.5
RZ out nz {RZOB}
CZ nz 0 {CZOB}
RLOAD out 0 {RL}
* estimated ELT 10 speaker; RSPK opens it when SPK=0
XSPK out spk ELT10_EST
RSPK spk 0 {1e9*(1-SPK)+1u}
.ends AMPCH
XL inL outL bp AMPCH
XR inR outR bp AMPCH
* ---- start near steady state (released after the operating point) ----
.ic V(raw)=407 V(bp)=400 V(xl:b2)=389 V(xl:b3)=358 V(xr:b2)=389 V(xr:b3)=358
* ---- stimulus & analysis (both channels driven, in phase) ----
.param AMP=0.5
VINL inL 0 SIN(0 {AMP} 1k)
VINR inR 0 SIN(0 {AMP} 1k)
.tran 0 0.42 0.4 10u
.four 1k 9 V(outL)
.meas TRAN VrmsL RMS V(outL) FROM 0.4 TO 0.42
.meas TRAN Bplus AVG V(bp) FROM 0.4 TO 0.42
.end
